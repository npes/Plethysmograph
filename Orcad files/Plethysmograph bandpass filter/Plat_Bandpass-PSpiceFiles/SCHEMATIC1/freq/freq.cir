** Profile: "SCHEMATIC1-freq"  [ C:\Users\Thomas\Desktop\Mapper\it - teknologi\thered_semester\elektronik\Plethysmograph\Orcad files\Plethysmograph bandpass filter\plat_bandpass-pspicefiles\schematic1\freq.sim ]

** Creating circuit file "freq.cir"
** WARNING: THIS AUTOMATICALLY GENERATED FILE MAY BE OVERWRITTEN BY SUBSEQUENT SIMULATIONS

*Libraries:
* Profile Libraries :
* Local Libraries :
* From [PSPICE NETLIST] section of C:\Cadence\SPB_Data\cdssetup\OrCAD_PSpice/16.6.0/PSpice.ini file:
.lib "nom.lib"
.lib "C:\Cadence\Company\OrCAD_PSpice\Models\pspice_demokit.lib"
.lib "C:\Cadence\Company\OrCAD_PSpice\Models\sample_models.lib"

*Analysis directives:
.AC DEC 10000 0.1 150
.OPTIONS ADVCONV
.PROBE64 V(alias(*)) I(alias(*)) W(alias(*)) D(alias(*)) NOISE(alias(*))
.INC "..\SCHEMATIC1.net"

.END
